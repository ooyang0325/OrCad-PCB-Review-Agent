; Original opt-in pure validation tests. No native geometry or persistence calls.
procedure(opaM1ProtocolChecks()
    let((output result checks destination left right)
        opaBootstrapGuard()
        destination = strcat(opaRoot "\\m1-native-validation.txt")
        opaRequire(!isFile(destination) "Native validation report already exists.")
        output = outfile(destination)
        opaRequire(output "Cannot open native validation report.")
        checks = 0
        unwindProtect(
            progn(
                foreach(value '("0" "-0" "1" "-1" "1.5" "999999999.999999999")
                    result = errset(opaNumber(value) t)
                    opaRequire(result "A valid protocol decimal was rejected.")
                    checks = checks + 1)
                foreach(value '("" "-" "01" "1." ".5" "1e2" "nan" "NaN"
                                "Infinity" "1+2" "(1)" "0/0" " 1" "1 "
                                "1000000000" "0.1234567890" "--1" "-01")
                    result = errset(opaNumber(value) t)
                    opaRequire(!result "An invalid protocol decimal was accepted.")
                    checks = checks + 1)
                foreach(value '("0" "10" "1.2345" "1.234500000" "-0.0001")
                    result = errset(opaTargetDbu(value) t)
                    opaRequire(result "A valid exact DBU coordinate was rejected.")
                    checks = checks + 1)
                foreach(value '("0.00001" "1.000000001" "-1.23456")
                    result = errset(opaTargetDbu(value) t)
                    opaRequire(!result "A fractional DBU request was accepted.")
                    checks = checks + 1)
                foreach(value '("0" "90" "180.0000" "270.0")
                    result = errset(opaTargetAngle(value) t)
                    opaRequire(result "A valid exact orthogonal angle was rejected.")
                    checks = checks + 1)
                foreach(value '("45" "360" "-90" "90.000000001")
                    result = errset(opaTargetAngle(value) t)
                    opaRequire(!result "An unsupported requested angle was accepted.")
                    checks = checks + 1)
                for(index 1 255
                    result = errset(opaField(symbolToString(intToChar(index))) nil)
                    opaRequire(if(index >= 32 && index <= 126 then result else !result)
                        "Printable-ASCII field validation changed.")
                    checks = checks + 1)
                opaRequire(opaCsv("") == "\"\"" "Empty CSV field changed.")
                opaRequire(opaCsv("\"") == "\"\"\"\"" "Single-quote CSV field changed.")
                opaRequire(opaCsv("a\"\"b") == "\"a\"\"\"\"b\"" "Repeated CSV quote escaping changed.")
                opaRequire(opaCsv("a,b") == "\"a,b\"" "CSV comma quoting changed.")
                checks = checks + 4
                left = atof("1000.0001")
                right = atof("1000.0002")
                opaRequire(left != right "Regression inputs must be distinct floats.")
                opaRequire(opaStable(left) != opaStable(right)
                    "Fine numeric changes collapse in stable atoms.")
                opaRequire(opaStable(list(list(left))) != opaStable(list(list(right)))
                    "Fine numeric changes collapse in dictionary keys.")
                opaRequire(opaCanonical(list(list("rule" left))) !=
                           opaCanonical(list(list("rule" right)))
                    "Fine rule changes collapse in the full scene.")
                opaRequire(opaStable(1) != opaStable(1.0)
                    "Stable numeric atoms lost their native type.")
                checks = checks + 4
                foreach(layer '("BOARD GEOMETRY/DESIGN_OUTLINE"
                    "BOARD GEOMETRY/OUTLINE" "PACKAGE KEEPIN/ALL"
                    "PACKAGE GEOMETRY/SILKSCREEN_TOP")
                    result = errset(opaRectangleFill(layer nil) t)
                    opaRequire(result "An original unfilled rectangle was rejected.")
                    result = errset(opaRectangleFill(layer t) t)
                    opaRequire(!result "Unexpected rectangle fill was accepted.")
                    checks = checks + 2)
                foreach(layer '("PACKAGE KEEPOUT/TOP" "PACKAGE GEOMETRY/PLACE_BOUND_TOP")
                    result = errset(opaRectangleFill(layer t) t)
                    opaRequire(result "An original filled rectangle was rejected.")
                    result = errset(opaRectangleFill(layer nil) t)
                    opaRequire(!result "Missing rectangle fill was accepted.")
                    checks = checks + 2)
                fprintf(output "pure_native_validation_cases %d\n" checks)
                fprintf(output "placement_calls_executed 0\nsave_calls_executed 0\n")
                fprintf(output "validation_complete t\n")
            )
            close(output)
        )
        t
    )
)

axlCmdRegister("opa_m1_protocol_checks" 'opaM1ProtocolChecks ?cmdType "general")

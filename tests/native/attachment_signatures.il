; Optional read-only native test. Writes/deletes only its own diagnostic files.
procedure(opaAttachmentSignatureAcceptance()
    let((report output path port signature started expected)
        opaBoardGuard()
        report = strcat(opaRoot "\\native-attachment-signatures.txt")
        path = strcat(opaRoot "\\native-attachment-signature.bin")
        opaRequire(!isFile(report) && !isFile(path) "Attachment test artifacts already exist.")
        output = outfile(report)
        opaRequire(output "Cannot create the attachment signature report.")
        expected = '(
            (0 "e3b0c44298fc1c149afbf4c8996fb92427ae41e4649b934ca495991b7852b855")
            (1 "6e340b9cffb37a989ca544e6bb780a2c78901d3fb33738768511a30617afa01d")
            (55 "463eb28e72f82e0a96c0a4cc53690c571281131f672aa229e0d45ae59b598b59")
            (56 "da2ae4d6b36748f2a318f23e7ab1dfdf45acdc9d049bd80e59de82a60895f562")
            (63 "29af2686fd53374a36b0846694cc342177e428d1647515f078784d69cdb9e488")
            (64 "fdeab9acf3710362bd2658cdc9a29e8f9c757fcf9811603a8c447cd1d9151108")
            (65 "4bfd2c8b6f1eec7a2afeb48b934ee4b2694182027e6d0fc075074f2fabb31781")
            (511 "8a6b2159bcb392e9050f093d7cea1010993973eb3164d0099d2961c3610fb4d7")
            (512 "110009dcee21620b166f3abfecb5eff7a873be729d1c2d53822e7acc5f34eb9b")
            (513 "2ac6d9e2b50bdd65511fb4dc0f24b7f6a0c1b2e92d1cf6901df565802e380234")
            (1048576 "fbbab289f7f94b25736c58be46a994c441fd02552cc6022352e3d86d2fab7c83"))
        unwindProtect(
            progn(
                foreach(size '(0 1 55 56 63 64 65 511 512 513 1048576)
                    port = axlDMOpenFile("TEMP" path "wb")
                    opaRequire(port "Cannot create the synthetic attachment bytes.")
                    when(size > 0
                        for(index 0 size - 1 putc(intToChar(mod(index 256)) port)))
                    axlDMClose(port)
                    started = cputime()
                    signature = opaManagedFileSignature(path size)
                    fprintf(output "%d %s %L\n" car(signature) cadr(cadr(signature)) cputime() - started)
                    opaRequire(car(signature) == size "Attachment signature length mismatch.")
                    opaRequire(cadr(cadr(signature)) == cadr(assoc(size expected))
                        "Native SHA-256 differs from the independent expected vector.")
                    when(size > 0
                        opaRequire(!errset(opaManagedFileSignature(path size - 1) t)
                            "Attachment signature accepted a truncated byte budget."))
                    opaRequire(deleteFile(path) "Cannot delete this synthetic attachment file."))
                opaBoardGuard()
                t
            )
            close(output)
        )
    )
)
